* AIPE DAB switching model level 2: circuit-sim-level2
* Generated by aipe_simulation.dab.netlist (AIPE-Simulation-Skills). Units: SI.
* spec_sha256=57052e6938b4a5d09ee66e9a3645903914e0fd9da458edde3cee7c8b874fc49e
* Conventions: v_ab=v(a)-v(b); v_cd=v(c)-v(d); i_L=i(Lext) from a towards transformer;
*   i_s=i(Vis) out of transformer secondary into node c; i_dc1=-i(V1); i_dc2=i(V2);
*   i(VsSk) positive = drain-to-source conduction; phi>0 => secondary lags, P: port1->port2;
*   t=0 is the centre of the primary positive half-cycle (S1,S4 on).
* timing.modulation = single-phase-shift
* timing.time_origin = centre of primary positive half-cycle (S1, S4 on)
* timing.period_s = 1e-05
* timing.phi_rad = 0.39269908169872414
* timing.phi_deg = 22.5
* timing.t_phi_s = 6.25e-07
* timing.dead_time_s = 2e-07
* timing.on_duration_s = 4.800000000000001e-06
* timing.sign_convention = phi > 0: secondary lags primary, power flows from port 1 to port 2
* spec_json={"dc_link1":{"capacitance":3e-05,"esl":2e-08,"esl_damping_resistance":0.0,"esr":0.005,"local_decoupling_capacitance":6.6e-06,"local_decoupling_esl":5e-10,"local_decoupling_esr":0.002,"source_damping_resistance":0.0,"source_inductance":1e-06,"source_resistance":0.05},"dc_link2":{"capacitance":0.0,"esl":0.0,"esl_damping_resistance":0.0,"esr":0.0,"local_decoupling_capacitance":0.0,"local_decoupling_esl":5e-10,"local_decoupling_esr":0.002,"source_damping_resistance":0.0,"source_inductance":0.0,"source_resistance":0.0},"dead_time":2e-07,"f_sw":100000.0,"l_ext":3.5e-05,"l_lk_p":0.0,"l_lk_s":0.0,"l_m":0.001,"level":2,"n_ratio":2.0,"name":"circuit-sim-level2","notes":["generated by AIPE-Workflows task circuit-sim-level2 run wf-dab-10kw-first"],"phi_deg":22.5,"port1":{"capacitance":0.0,"esl":0.0,"esl_damping_resistance":0.0,"esr":0.0,"initial_voltage":null,"load_resistance":0.0,"local_decoupling_capacitance":0.0,"local_decoupling_esl":5e-10,"local_decoupling_esr":0.002,"type":"voltage_source"},"port2":{"capacitance":6e-05,"esl":2e-08,"esl_damping_resistance":0.0,"esr":0.005,"initial_voltage":399.0,"load_resistance":16.0,"local_decoupling_capacitance":6.6e-06,"local_decoupling_esl":5e-10,"local_decoupling_esr":0.002,"type":"rc_load"},"r_series_p":0.02,"r_series_s":0.0,"sim":{"abstol":1e-08,"chgtol":1e-14,"cycles":160,"initial_magnetising_current":null,"initial_series_current":14.285714285714288,"max_step_fraction":400,"maxord":2,"method":"gear","output_from_cycle":0,"reltol":0.0001,"timeout_s":1800.0,"use_initial_conditions":true,"vntol":1e-05},"switch":{"c_oss":1.87e-10,"c_oss_esr":1.0,"d_cjo":0.0,"d_is":1e-12,"d_n":4.0,"d_rs":0.117,"gate_rise_fall":2e-08,"gate_voltage":15.0,"model":"auto","r_off":10000000.0,"r_on":0.0587,"snubber_c":0.0,"snubber_r":100.0,"transition_voltage":1.5},"v1":800.0,"v2":400.0}

* ---- DC port 1 (source side)
V1 src1 0 DC 800
Rsrc1 src1 src1b 0.05
Lsrc1 src1b p_pos 1e-06
Rsrcd1 src1b p_pos 73.1272424127
Resr1 p_pos cdc1x 0.005
Lesl1 cdc1x cdc1y 2e-08
Resld1 cdc1x cdc1y 10.3417537999
Cdc1 cdc1y 0 3e-05 IC=800
Rloc1 p_pos loc1x 0.002
Lloc1 loc1x loc1y 5e-10
Rlocd1 loc1x loc1y 1.63517485042
Cloc1 loc1y 0 6.6e-06 IC=800

* ---- DC port 2 (bidirectional port)
Resr2 s_pos c2x 0.005
Lesl2 c2x c2y 2e-08
Resld2 c2x c2y 10.3417537999
C2 c2y 0 6e-05 IC=399
Rloc2 s_pos loc2x 0.002
Lloc2 loc2x loc2y 5e-10
Rlocd2 loc2x loc2y 1.63517485042
Cloc2 loc2y 0 6.6e-06 IC=399
* V2 is a 0 V sense source in series with the load so that i(V2) is the load current
Rload2 s_pos ld2 16
V2 ld2 0 DC 0

* ---- Switches (behavioural channel model) + antiparallel diode (+ optional linear Coss), with 0 V current sense
VsS1 p_pos p_pos_s1 DC 0
BS1 p_pos_s1 a I=V(p_pos_s1,a)*(17.0357751278*(min(max((V(g1)-6)/3,0),1))*(min(max((V(g1)-6)/3,0),1))*(3-2*(min(max((V(g1)-6)/3,0),1)))+1e-07)
D1 a p_pos_s1 dmod
Coss1 p_pos_s1 cossx1 1.87e-10
Rcoss1 cossx1 a 1
VsS2 a a_s2 DC 0
BS2 a_s2 0 I=V(a_s2,0)*(17.0357751278*(min(max((V(g2)-6)/3,0),1))*(min(max((V(g2)-6)/3,0),1))*(3-2*(min(max((V(g2)-6)/3,0),1)))+1e-07)
D2 0 a_s2 dmod
Coss2 a_s2 cossx2 1.87e-10
Rcoss2 cossx2 0 1
VsS3 p_pos p_pos_s3 DC 0
BS3 p_pos_s3 b I=V(p_pos_s3,b)*(17.0357751278*(min(max((V(g3)-6)/3,0),1))*(min(max((V(g3)-6)/3,0),1))*(3-2*(min(max((V(g3)-6)/3,0),1)))+1e-07)
D3 b p_pos_s3 dmod
Coss3 p_pos_s3 cossx3 1.87e-10
Rcoss3 cossx3 b 1
VsS4 b b_s4 DC 0
BS4 b_s4 0 I=V(b_s4,0)*(17.0357751278*(min(max((V(g4)-6)/3,0),1))*(min(max((V(g4)-6)/3,0),1))*(3-2*(min(max((V(g4)-6)/3,0),1)))+1e-07)
D4 0 b_s4 dmod
Coss4 b_s4 cossx4 1.87e-10
Rcoss4 cossx4 0 1
VsS5 s_pos s_pos_s5 DC 0
BS5 s_pos_s5 c I=V(s_pos_s5,c)*(17.0357751278*(min(max((V(g5)-6)/3,0),1))*(min(max((V(g5)-6)/3,0),1))*(3-2*(min(max((V(g5)-6)/3,0),1)))+1e-07)
D5 c s_pos_s5 dmod
Coss5 s_pos_s5 cossx5 1.87e-10
Rcoss5 cossx5 c 1
VsS6 c c_s6 DC 0
BS6 c_s6 0 I=V(c_s6,0)*(17.0357751278*(min(max((V(g6)-6)/3,0),1))*(min(max((V(g6)-6)/3,0),1))*(3-2*(min(max((V(g6)-6)/3,0),1)))+1e-07)
D6 0 c_s6 dmod
Coss6 c_s6 cossx6 1.87e-10
Rcoss6 cossx6 0 1
VsS7 s_pos s_pos_s7 DC 0
BS7 s_pos_s7 d I=V(s_pos_s7,d)*(17.0357751278*(min(max((V(g7)-6)/3,0),1))*(min(max((V(g7)-6)/3,0),1))*(3-2*(min(max((V(g7)-6)/3,0),1)))+1e-07)
D7 d s_pos_s7 dmod
Coss7 s_pos_s7 cossx7 1.87e-10
Rcoss7 cossx7 d 1
VsS8 d d_s8 DC 0
BS8 d_s8 0 I=V(d_s8,0)*(17.0357751278*(min(max((V(g8)-6)/3,0),1))*(min(max((V(g8)-6)/3,0),1))*(3-2*(min(max((V(g8)-6)/3,0),1)))+1e-07)
D8 0 d_s8 dmod
Coss8 d_s8 cossx8 1.87e-10
Rcoss8 cossx8 0 1

* ---- Gate signals (ideal, referenced to ground)
Vg1 g1 0 PULSE(15 0 2.39e-06 2e-08 2e-08 5.18e-06 1e-05)
Vg2 g2 0 PULSE(0 15 2.59e-06 2e-08 2e-08 4.78e-06 1e-05)
Vg3 g3 0 PULSE(0 15 2.59e-06 2e-08 2e-08 4.78e-06 1e-05)
Vg4 g4 0 PULSE(15 0 2.39e-06 2e-08 2e-08 5.18e-06 1e-05)
Vg5 g5 0 PULSE(15 0 3.015e-06 2e-08 2e-08 5.18e-06 1e-05)
Vg6 g6 0 PULSE(0 15 3.215e-06 2e-08 2e-08 4.78e-06 1e-05)
Vg7 g7 0 PULSE(0 15 3.215e-06 2e-08 2e-08 4.78e-06 1e-05)
Vg8 g8 0 PULSE(15 0 3.015e-06 2e-08 2e-08 5.18e-06 1e-05)

* ---- Series path (primary side): external inductance, resistance, leakage
Lext a x1 3.5e-05 IC=14.2857142857
Rsp x1 x2 0.02
Vlkp x2 tp DC 0

* ---- Ideal transformer n = Np/Ns = 2 with magnetising inductance (primary referred)
Lm tp b 0.001 IC=-0.5
Esec ts0 d tp b 0.5
Vis ts0 ts DC 0
Fpri tp b Vis 0.5

* ---- Series path (secondary side)
Vlks ts x3 DC 0
Rss x3 c 1e-06

* ---- Device models
.model swmod SW(Ron=0.0587 Roff=10000000 Vt=7.5 Vh=1.5)
.model dmod D(Is=1e-12 N=4 Rs=0.117 Cjo=0 Vj=0.7 M=0.5 Tt=0)

* ---- Solver settings
.options reltol=0.0001 abstol=1e-08 vntol=1e-05 chgtol=1e-14 method=gear maxord=2
.options itl4=200 noinit
.tran 2.5e-08 0.0016 0 2.5e-08 uic
.save v(a) v(b) v(c) v(d) v(p_pos) v(s_pos) v(tp) v(ts) v(x1) i(Lext) i(Lm) i(Vis) i(V1) i(V2) i(VsS1) i(VsS2) i(VsS3) i(VsS4) i(VsS5) i(VsS6) i(VsS7) i(VsS8) v(g1) v(g2) v(g3) v(g4) v(g5) v(g6) v(g7) v(g8)
.end
