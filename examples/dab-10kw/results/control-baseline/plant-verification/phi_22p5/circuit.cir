* AIPE DAB switching model level 1: dab-level1-plant-verification-phi22.5
* Generated by aipe_simulation.dab.netlist (AIPE-Simulation-Skills). Units: SI.
* spec_sha256=37adeb1009cdfb8ad130f30509b33f0485c8e84254abdda677e698dec8de76bc
* Conventions: v_ab=v(a)-v(b); v_cd=v(c)-v(d); i_L=i(Lext) from a towards transformer;
*   i_s=i(Vis) out of transformer secondary into node c; i_dc1=-i(V1); i_dc2=i(V2);
*   i(VsSk) positive = drain-to-source conduction; phi>0 => secondary lags, P: port1->port2;
*   t=0 is the centre of the primary positive half-cycle (S1,S4 on).
* timing.modulation = single-phase-shift
* timing.time_origin = centre of primary positive half-cycle (S1, S4 on)
* timing.period_s = 1e-05
* timing.phi_rad = 0.39269908169872414
* timing.phi_deg = 22.5
* timing.t_phi_s = 6.25e-07
* timing.dead_time_s = 0.0
* timing.on_duration_s = 5e-06
* timing.sign_convention = phi > 0: secondary lags primary, power flows from port 1 to port 2
* spec_json={"dc_link1":{"capacitance":0.0,"esl":0.0,"esl_damping_resistance":0.0,"esr":0.0,"local_decoupling_capacitance":0.0,"local_decoupling_esl":5e-10,"local_decoupling_esr":0.002,"source_damping_resistance":0.0,"source_inductance":0.0,"source_resistance":0.0},"dc_link2":{"capacitance":0.0,"esl":0.0,"esl_damping_resistance":0.0,"esr":0.0,"local_decoupling_capacitance":0.0,"local_decoupling_esl":5e-10,"local_decoupling_esr":0.002,"source_damping_resistance":0.0,"source_inductance":0.0,"source_resistance":0.0},"dead_time":0.0,"f_sw":100000.0,"l_ext":3.5e-05,"l_lk_p":0.0,"l_lk_s":0.0,"l_m":0.001,"level":1,"n_ratio":2.0,"name":"dab-level1-plant-verification-phi22.5","notes":[],"phi_deg":22.5,"port1":{"capacitance":0.0,"esl":0.0,"esl_damping_resistance":0.0,"esr":0.0,"initial_voltage":null,"load_resistance":0.0,"local_decoupling_capacitance":0.0,"local_decoupling_esl":5e-10,"local_decoupling_esr":0.002,"type":"voltage_source"},"port2":{"capacitance":0.0,"esl":0.0,"esl_damping_resistance":0.0,"esr":0.0,"initial_voltage":null,"load_resistance":0.0,"local_decoupling_capacitance":0.0,"local_decoupling_esl":5e-10,"local_decoupling_esr":0.002,"type":"voltage_source"},"r_series_p":0.02,"r_series_s":0.0,"sim":{"abstol":1e-09,"chgtol":1e-14,"cycles":12,"initial_magnetising_current":null,"initial_series_current":14.285714285714288,"max_step_fraction":200,"maxord":2,"method":"gear","output_from_cycle":0,"reltol":0.0001,"timeout_s":1800.0,"use_initial_conditions":true,"vntol":1e-06},"switch":{"c_oss":0.0,"c_oss_esr":1.0,"d_cjo":0.0,"d_is":1e-12,"d_n":1.0,"d_rs":0.001,"gate_rise_fall":1e-08,"gate_voltage":15.0,"model":"auto","r_off":10000000.0,"r_on":0.001,"snubber_c":0.0,"snubber_r":100.0,"transition_voltage":1.5},"v1":800.0,"v2":400.0}

* ---- DC port 1 (source side)
V1 p_pos 0 DC 800

* ---- DC port 2 (bidirectional port)
V2 s_pos 0 DC 400

* ---- Switches (sw channel model) + antiparallel diode (+ optional linear Coss), with 0 V current sense
VsS1 p_pos p_pos_s1 DC 0
S1 p_pos_s1 a g1 0 swmod
D1 a p_pos_s1 dmod
VsS2 a a_s2 DC 0
S2 a_s2 0 g2 0 swmod
D2 0 a_s2 dmod
VsS3 p_pos p_pos_s3 DC 0
S3 p_pos_s3 b g3 0 swmod
D3 b p_pos_s3 dmod
VsS4 b b_s4 DC 0
S4 b_s4 0 g4 0 swmod
D4 0 b_s4 dmod
VsS5 s_pos s_pos_s5 DC 0
S5 s_pos_s5 c g5 0 swmod
D5 c s_pos_s5 dmod
VsS6 c c_s6 DC 0
S6 c_s6 0 g6 0 swmod
D6 0 c_s6 dmod
VsS7 s_pos s_pos_s7 DC 0
S7 s_pos_s7 d g7 0 swmod
D7 d s_pos_s7 dmod
VsS8 d d_s8 DC 0
S8 d_s8 0 g8 0 swmod
D8 0 d_s8 dmod

* ---- Gate signals (ideal, referenced to ground)
Vg1 g1 0 PULSE(15 0 2.495e-06 1e-08 1e-08 4.99e-06 1e-05)
Vg2 g2 0 PULSE(0 15 2.495e-06 1e-08 1e-08 4.99e-06 1e-05)
Vg3 g3 0 PULSE(0 15 2.495e-06 1e-08 1e-08 4.99e-06 1e-05)
Vg4 g4 0 PULSE(15 0 2.495e-06 1e-08 1e-08 4.99e-06 1e-05)
Vg5 g5 0 PULSE(15 0 3.12e-06 1e-08 1e-08 4.99e-06 1e-05)
Vg6 g6 0 PULSE(0 15 3.12e-06 1e-08 1e-08 4.99e-06 1e-05)
Vg7 g7 0 PULSE(0 15 3.12e-06 1e-08 1e-08 4.99e-06 1e-05)
Vg8 g8 0 PULSE(15 0 3.12e-06 1e-08 1e-08 4.99e-06 1e-05)

* ---- Series path (primary side): external inductance, resistance, leakage
Lext a x1 3.5e-05 IC=14.2857142857
Rsp x1 x2 0.02
Vlkp x2 tp DC 0

* ---- Ideal transformer n = Np/Ns = 2 with magnetising inductance (primary referred)
Lm tp b 0.001 IC=-0.5
Esec ts0 d tp b 0.5
Vis ts0 ts DC 0
Fpri tp b Vis 0.5

* ---- Series path (secondary side)
Vlks ts x3 DC 0
Rss x3 c 1e-06

* ---- Device models
.model swmod SW(Ron=0.001 Roff=10000000 Vt=7.5 Vh=1.5)
.model dmod D(Is=1e-12 N=1 Rs=0.001 Cjo=0 Vj=0.7 M=0.5 Tt=0)

* ---- Solver settings
.options reltol=0.0001 abstol=1e-09 vntol=1e-06 chgtol=1e-14 method=gear maxord=2
.options itl4=200 noinit
.tran 5e-08 0.00012 0 5e-08 uic
.save v(a) v(b) v(c) v(d) v(p_pos) v(s_pos) v(tp) v(ts) v(x1) i(Lext) i(Lm) i(Vis) i(V1) i(V2) i(VsS1) i(VsS2) i(VsS3) i(VsS4) i(VsS5) i(VsS6) i(VsS7) i(VsS8) v(g1) v(g2) v(g3) v(g4) v(g5) v(g6) v(g7) v(g8)
.end
